simulator( 'spectre )
design( "/userspace/d/dwortmann/cadence/simulation/project_state_machine_PULSELATCH_tb/spectre/schematic/netlist/netlist")
resultsDir( "/userspace/d/dwortmann/cadence/simulation//spectre/schematic")
modelFile(
    '("/userspace/d/dwortmann/ece555/cadence/modelfile18" "")
)
stimulusFile( ?xlate nil
    "/userspace/d/dwortmann/Desktop/ece555/cadence/vectors.stim"
)
analysis('tran ?stop "125n" ?errpreset "moderate" )
envOption(
		'analysisOrder list("tran")
		'switchViewList '( "spectre cmos_sch cmos.sch extracted schematic" )
)
save( 'v "/clk" "/cin" "/src0_sel" "/src1_sel" "/rshft<1>" "/rshft<0>" )
save( 'i "/V0/PLUS" )
temp( 27 )
createNetlist()
run()
selectResults("tran")
ocnPrint(?output "cadence/simulation/sim_out.txt" ?precision 16 ?numberNotation `scientific v("/clk") v("/cin") v("/src0_sel") v("/src1_sel") v("/rshft<1>") v("/rshft<0>") i("/V0/PLUS") ?step 0.025n)
id=ipcBeginProcess("~kgarg/ece555_scripts/check_res.pl project_state_machine_PULSELATCH_tb")
ipcWaitForProcess(id)
